* Rev 3.0: 40-JPY Red LED-as-Photodiode 5.0V Reverse-Bias Optical Ranging (CH32X035 PIOC)
* Physical reverse-biased PN junction: Cj=30pF, photocurrent rolls off smoothly to 0V, forward LED clamp
.model D_RED D(IS=1e-18 N=1.8 RS=5 CJO=30p VJ=1.6)
C_J1 led_floor 0 30p IC=5.0
D_1  0 led_floor D_RED
B_PH1 led_floor 0 I = 320n * (0.5 + 0.5 * tanh(V(led_floor) * 20))
R_LK1 led_floor 0 250Meg

C_J2 led_cliff 0 30p IC=5.0
D_2  0 led_cliff D_RED
B_PH2 led_cliff 0 I = 28n * (0.5 + 0.5 * tanh(V(led_cliff) * 20))
R_LK2 led_cliff 0 250Meg

.tran 2u 3.0m 0 2u uic
.control
run
set wr_vecnames
wrdata /home/antigravity/sc8z35a-collab/Zphone-2/simulations/results/spice_led_sensor.txt v(led_floor) v(led_cliff)
quit
.endc
.end
